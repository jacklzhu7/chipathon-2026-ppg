.title MFB LPF 2nd-order — fc=10Hz Butterworth, differential FDA
.include /foss/pdks/gf180mcuD/libs.tech/ngspice/design.ngspice
.lib /foss/pdks/gf180mcuD/libs.tech/ngspice/sm141064.ngspice typical
.include /foss/designs/sscs-chipathon-2026/filters/foldedcasc_fda.spice

.param fc=11.5 Q=0.70710678 K=1
.param w0='2*3.14159265358979*fc'
.param C2=100n
.param C1='4*Q*Q*(K+1)*C2'
.param R2='1/(2*Q*w0*C2)*(1+sqrt(1-4*Q*Q*(K+1)*C2/C1))'
.param R1='R2/K'
.param R3='1/(w0*w0*C1*C2*R2)'

VVDD VDD GND 3.3
VVb1 Vb1 GND 1.4
VVb2 Vb2 GND 1.6
VVb3 Vb3 GND 0.8
VVb4 Vb4 GND 2.3
IB   ibn GND dc 25u

Vip in_p GND dc 1.7 ac 0.5
Vin in_n GND dc 1.7 ac -0.5

* positive: node A = ap (R-C junction), summing node = sp -> Vinp
* feedback output for this half = out_n (crossed, matches verified LPF)
R1p in_p  ap  {R1}
R2p out_n ap  {R2}
R3p ap    sp  {R3}
C1p ap    GND {C1}
C2p sp    out_n {C2}

* negative half, summing node sn -> Vinn, feedback from out_p
R1n in_n  an  {R1}
R2n out_p an  {R2}
R3n an    sn  {R3}
C1n an    GND {C1}
C2n sn    out_p {C2}

XFDA1 VDD Vb2 out_p out_n Vb1 ibn sn GND sp Vb3 Vb4 foldedcasc_cmfb_forsym

.ic v(out_p)=1.7 v(out_n)=1.7 v(sp)=1.7 v(sn)=1.7 v(ap)=1.7 v(an)=1.7

.control
ac dec 40 0.01 10k
let vdiff = v(out_p)-v(out_n)
let vdb = db(vdiff)
meas ac fc_3db  WHEN vdb=-3
meas ac gpass   FIND vdb AT=0.1
meas ac roll100 FIND vdb AT=100
echo "R1 R2 R3 C1 C2:"
print R1 R2 R3 C1 C2
plot vdb title "MFB LPF 2nd order"
.endc
.end
