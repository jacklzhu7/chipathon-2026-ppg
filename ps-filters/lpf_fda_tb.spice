.title Active RC LPF fc=10Hz with real FDA (first order)
* DC gain = Rf/R1 = 1, pole at 1/(2pi*Rf*Cf) = 10Hz
* Inverting FD config: feedback from opposite output = negative fb

.include /foss/pdks/gf180mcuD/libs.tech/ngspice/design.ngspice
.lib /foss/pdks/gf180mcuD/libs.tech/ngspice/sm141064.ngspice typical
.include /foss/designs/sscs-chipathon-2026/filters/cascode_cmfb.spice

VVDD   VDD   GND  dc 3.3
VVb1   Vb1   GND  dc 1.6
VVb2   Vb2   GND  dc 1.8
VVbias Vbias GND  dc 0.8025

* Input — 1.2V CM
Vip  in_p  GND  dc 1.2 ac 0.5
Vin  in_n  GND  dc 1.2 ac -0.5

* ============================================================
* ACTIVE RC LPF — first order, fc=10Hz
* in_p -> R1 -> Xp (FDA Vinp)
* Voutn -> Rf -> Xp  (feedback from inverting output)
* Voutn -> Cf -> Xp  (sets the pole)
* in_n -> R1 -> Xn (FDA Vinn)
* Voutp -> Rf -> Xn
* Voutp -> Cf -> Xn
* ============================================================
R1p   in_p   Xp    100k
Rfp   Voutn  Xp    100k
Cfp   Voutn  Xp    100n

R1n   in_n   Xn    100k
Rfn   Voutp  Xn    100k
Cfn   Voutp  Xn    100n

XFDA1 Xp Xn Voutp Voutn VDD GND Vb1 Vb2 Vb3_1 Vbias FDA

.ic v(Voutp)=1.7 v(Voutn)=1.7
.ic v(Xp)=1.45 v(Xn)=1.45

.ac dec 20 0.01 10k

.control
run
let Vdiff_lpf = v(Voutp) - v(Voutn)
plot db(Vdiff_lpf) title "Active RC LPF fc=10Hz"
.endc
.end
