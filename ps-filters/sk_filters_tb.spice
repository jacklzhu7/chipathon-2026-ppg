.title Fully Differential Sallen-Key HPF + LPF
Vip   in_p  GND   AC 0.5
Vin   in_n  GND   AC -0.5
C1p   in_p  Ap    1u
C2p   Ap    Bp    1u
R2p   Bp    GND   1.125Meg
Ehp   HPF_p GND   VCVS Bp HPF_p 1e6
R1p   Ap    HPF_p 1.125Meg
C1n   in_n  An    1u
C2n   An    Bn    1u
R2n   Bn    GND   1.125Meg
Ehn   HPF_n GND   VCVS Bn HPF_n 1e6
R1n   An    HPF_n 1.125Meg
R3p   HPF_p Cp    11.25k
R4p   Cp    Dp    11.25k
C3p   Cp    LPF_p 1u
C4p   Dp    GND   1u
Elp   LPF_p GND   VCVS Dp LPF_p 1e6
R3n   HPF_n Cn    11.25k
R4n   Cn    Dn    11.25k
C3n   Cn    LPF_n 1u
C4n   Dn    GND   1u
Eln   LPF_n GND   VCVS Dn LPF_n 1e6
.ac dec 100 0.001 1k
.control
run
let Vdiff_hpf = v(HPF_p) - v(HPF_n)
let Vdiff_lpf = v(LPF_p) - v(LPF_n)
plot db(v(HPF_p))
plot db(Vdiff_hpf)
plot db(Vdiff_lpf)
plot db(Vdiff_hpf) db(Vdiff_lpf)
.endc
.end
