.title PPG bandpass from schematics — 0.1–10Hz
.include /foss/pdks/gf180mcuD/libs.tech/ngspice/design.ngspice
.lib /foss/pdks/gf180mcuD/libs.tech/ngspice/sm141064.ngspice typical
.include /foss/designs/sscs-chipathon-2026/filters/bandpass.spice

VVDD VDD GND dc 3.3
VVb1 Vb1 GND dc 1.4
VVb2 Vb2 GND dc 1.6
VVb3 Vb3 GND dc 0.8
VVb4 Vb4 GND dc 2.3
IB Ibias25u GND dc 25u
VCM CM GND dc 1.7

Vip in_p GND dc 1.7 ac 0.5
Vin in_n GND dc 1.7 ac -0.5

.ic v(mid_p)=1.7 v(mid_n)=1.7 v(out_p)=1.7 v(out_n)=1.7
.ic v(xlpf1.xp)=1.7 v(xlpf1.xn)=1.7

.ac dec 20 0.001 1k
.control
run
let vdiff = v(out_p)-v(out_n)
let vmid = v(mid_p)-v(mid_n)
let vdb = db(vdiff)
plot db(vmid) vdb title "HPF stage and full bandpass"
meas ac f_lo WHEN vdb=-3 CROSS=1
meas ac f_hi WHEN vdb=-3 CROSS=2
.endc
.end
