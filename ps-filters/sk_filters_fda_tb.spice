.title Fully Differential Sallen-Key HPF+LPF with Real FDA

.include /foss/pdks/gf180mcuD/libs.tech/ngspice/design.ngspice
.lib /foss/pdks/gf180mcuD/libs.tech/ngspice/sm141064.ngspice typical
.include /foss/designs/sscs-chipathon-2026/filters/cascode_cmfb.spice

* ============================================================
* SUPPLIES AND BIAS
* ============================================================
VVDD   VDD   GND  dc 3.3
VVb1   Vb1   GND  dc 1.6
VVb2   Vb2   GND  dc 1.8
VVbias Vbias GND  dc 0.8025

* ============================================================
* DIFFERENTIAL INPUT — 1.2V CM + AC signal
* ============================================================
Vip  in_p  GND  dc 1.2 ac 0.5
Vin  in_n  GND  dc 1.2 ac -0.5

* ============================================================
* HPF STAGE — fc=0.1Hz
* Topology: C1->A->C2->B->FDA+ output
* R1: A->HPF_p/n feedback
* R2: B->GND
* ============================================================
C1p  in_p  Ap    1u
C2p  Ap    Bp    1u
R2p  Bp    GND   1.125Meg
R1p  Ap    HPF_p 1.125Meg

C1n  in_n  An    1u
C2n  An    Bn    1u
R2n  Bn    GND   1.125Meg
R1n  An    HPF_n 1.125Meg

XFDA1 Bp Bn HPF_p HPF_n VDD GND Vb1 Vb2 Vb3_1 Vbias FDA

* ============================================================
* LPF STAGE — fc=10Hz
* Direct connection HPF->LPF (both at same CM=1.7V output)
* R3->C->R4->D->FDA2
* C3: C->LPF feedback
* C4: D->GND
* ============================================================
R3p  HPF_p  Cp    11.25k
R4p  Cp     Dp    11.25k
C3p  Cp     LPF_p 1u
C4p  Dp     GND   1u

R3n  HPF_n  Cn    11.25k
R4n  Cn     Dn    11.25k
C3n  Cn     LPF_n 1u
C4n  Dn     GND   1u

XFDA2 Dp Dn LPF_p LPF_n VDD GND Vb1 Vb2 Vb3_2 Vbias FDA

* ============================================================
* ANALYSIS
* ============================================================
.ic v(HPF_p)=1.7 v(HPF_n)=1.7 v(LPF_p)=1.7 v(LPF_n)=1.7
.ic v(Bp)=1.2 v(Bn)=1.2 v(Dp)=1.7 v(Dn)=1.7

.ac dec 20 0.001 1k

.control
run
let Vdiff_hpf = v(HPF_p) - v(HPF_n)
let Vdiff_lpf = v(LPF_p) - v(LPF_n)
plot db(Vdiff_hpf) title "HPF differential Bode"
plot db(Vdiff_lpf) title "LPF differential Bode"
plot db(Vdiff_hpf) db(Vdiff_lpf) title "HPF+LPF combined"
.endc

.end
